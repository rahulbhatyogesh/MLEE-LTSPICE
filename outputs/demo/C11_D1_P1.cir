* C11_D1_P1
* Generated by circuit2spice from a hand-drawn schematic
* WARNING: no ground symbol detected; using the highest-degree node as the reference node

C1 N001 0 1u
R1 N002 0 1k
C2 N003 0 1u
V1 N002 N003 DC 5
R2 N003 N001 1k

.ac dec 50 10 1Meg
.end
