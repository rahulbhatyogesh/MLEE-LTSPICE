* rc_lowpass
* Generated by circuit2spice from a hand-drawn schematic

V1 N001 0 DC 1
R1 N001 N002 1k
C1 N002 0 1u

.op
.end
