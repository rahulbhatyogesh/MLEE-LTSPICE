* divider
* Generated by circuit2spice from a hand-drawn schematic

V1 N001 0 DC 5
R1 N001 N002 1k
R2 N002 0 2k

.op
.end
