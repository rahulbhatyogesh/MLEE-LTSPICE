* series_rlc
* Generated by circuit2spice from a hand-drawn schematic

V1 N001 0 DC 1
R1 N001 N002 10
L1 N002 N003 1m
C1 N003 0 1u

.op
.end
