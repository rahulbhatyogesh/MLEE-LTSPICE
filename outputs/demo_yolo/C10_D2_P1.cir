* C10_D2_P1
* Generated by circuit2spice from a hand-drawn schematic
* WARNING: no ground symbol detected; using the highest-degree node as the reference node

R1 0 N001 1k
V1 N002 N001 DC 5
L1 0 N003 1m
C1 N002 N004 1u

.ac dec 50 10 1Meg
.end
