* C2_D1_P1
* Generated by circuit2spice from a hand-drawn schematic

R1 N001 N002 1k
V1 0 N002 DC 5
R2 N003 N002 1k
Q1 N001 N004 N003 QMOD
C1 N001 N005 1u
C2 N006 N004 1u
V2 N007 N005 DC 5
R3 N007 N001 1k
R4 N008 N007 1k
R5 N006 N007 1k

.model QMOD NPN(Bf=100 Is=1e-15)
.op
.end
