* C1_D1_P1
* Generated by circuit2spice from a hand-drawn schematic
* WARNING: resistor at (512,412) found only 1/2 terminals; left unconnected
* WARNING: resistor at (368,418) found only 1/2 terminals; left unconnected
* WARNING: diode at (388,482) found only 1/2 terminals; left unconnected
* WARNING: R1 has all terminals on one node (short circuit)
* WARNING: R2 has all terminals on one node (short circuit)
* WARNING: D1 has all terminals on one node (short circuit)

Q1 N001 N002 0 QMOD
V1 N003 N002 DC 5
R1 0 NC 1k
R2 N001 NC 1k
C1 N003 0 1u
D1 N003 NC DMOD

.model QMOD NPN(Bf=100 Is=1e-15)
.model DMOD D(Is=1e-14 Rs=0.1 N=1)
.op
.end
