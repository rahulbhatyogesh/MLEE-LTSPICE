* C3_D1_P1
* Generated by circuit2spice from a hand-drawn schematic
* WARNING: no ground symbol detected; using the highest-degree node as the reference node

R1 0 N001 1k
V1 0 N002 DC 5
C1 N003 N004 1u

.op
.end
